* Verici + 3 km DSL damari (damar-toprak, ~50 nF/km, ~140 ohm/km)
.include modeller.lib
VB vcc 0 9
* U1 titresim osilatoru
R1 vcc dis1 10k
R2 dis1 tc1 68k
C2 tc1 0 1u
C3 cv1 0 10n
XU1 vcc 0 tc1 tc1 cv1 dis1 lfo NE555
R5 lfo cv2 10k
* U2 ton osilatoru
R3 vcc dis2 1k
R4 dis2 tc2 6.8k
C4 tc2 0 100n
XU2 vcc 0 tc2 tc2 cv2 dis2 ton NE555
* cikis
R6 ton cl 470
D2 cl vcc D1N4148
D3 0 cl D1N4148
C5 cl kirmizi 1u
* 3 km hat: 3 RC hucre
Rh1 kirmizi h1 140
Ch1 h1 0 50n
Rh2 h1 h2 140
Ch2 h2 0 50n
Rh3 h2 uzak 140
Ch3 uzak 0 50n
.model D1N4148 D(Is=2.5n Rs=0.6 N=1.75 Cjo=4p Bv=100)
.tran 5u 2.5 0 5u
.control
run
wrdata verici.dat v(lfo) v(ton) v(kirmizi) v(uzak) v(cv2)
.endc
.end
